$ Spice netlist generated by v2lvs
$ v2022.2_15.10    Thu Apr 7 16:50:53 PDT 2022
.INCLUDE "/opt/tools/Cadence/Cadence_lib/scl_pdk_v3/SCLPDK_V3.0_KIT/scl180/iopad/cio150/6M1L/cdl/tsl18cio150.cdl"
.INCLUDE "/opt/tools/Cadence/Cadence_lib/scl_pdk_v3/SCLPDK_V3.0_KIT/scl180/stdcell/fs120/6M1L/cdl/scl18fs120_supply_pins.cdl"
*.BUSDELIMITER [

.SUBCKT buffd1 I Z VSS VDD
.ENDS

.SUBCKT dl03d1 I Z VSS VDD
.ENDS

.SUBCKT dfcrq1 CDN CP D Q VSS VDD
.ENDS

.SUBCKT decrq1 CDN CP D ENN Q VSS VDD
.ENDS

.SUBCKT nd02d1 A1 A2 ZN VSS VDD
.ENDS

.SUBCKT oan211d1 A B C1 C2 ZN VSS VDD
.ENDS

.SUBCKT oai21d1 A B1 B2 ZN VSS VDD
.ENDS

.SUBCKT nr03d1 A1 A2 A3 ZN VSS VDD
.ENDS

.SUBCKT aoim211d1 A B C1 C2 ZN VSS VDD
.ENDS

.SUBCKT nd03d1 A1 A2 A3 ZN VSS VDD
.ENDS

.SUBCKT inv0d1 I ZN VSS VDD
.ENDS

.SUBCKT dfcrb1 CDN CP D Q QN VSS VDD
.ENDS

.SUBCKT pc3c01 CCLK CP VSSO VSS VDDO VDD
.ENDS

.SUBCKT pc3d01 PAD CIN VSSO VSS VDDO VDD
.ENDS

.SUBCKT pvdi VSSO VSS VDDO VDD
.ENDS

.SUBCKT pv0i VSSO VSS VDDO VDD
.ENDS

.SUBCKT pvda VSSO VSS VDDO VDD
.ENDS

.SUBCKT pv0a VSSO VSS VDDO VDD
.ENDS

.SUBCKT pc3o01 I PAD VSSO VSS VDDO VDD
.ENDS

.SUBCKT fpga_wrapper clk rst_n start sw[3] sw[2] sw[1] sw[0] led[3] led[2]
+ led[1] led[0] done_led VDD_CORE VSS_CORE
XFE_PHC11_rst_n_pad buffd1 $PINS I=FE_PHN7_rst_n_pad Z=FE_PHN11_rst_n_pad
+ VSS=VSS_CORE VDD=VDD_CORE
XFE_PHC10_n_9 dl03d1 $PINS I=n_9 Z=FE_PHN10_n_9 VSS=VSS_CORE VDD=VDD_CORE
XFE_PHC9_n_8 dl03d1 $PINS I=n_8 Z=FE_PHN9_n_8 VSS=VSS_CORE VDD=VDD_CORE
XFE_PHC8_n_4 dl03d1 $PINS I=n_4 Z=FE_PHN8_n_4 VSS=VSS_CORE VDD=VDD_CORE
XFE_PHC7_rst_n_pad dl03d1 $PINS I=rst_n Z=FE_PHN7_rst_n_pad VSS=VSS_CORE
+ VDD=VDD_CORE
XFE_PHC6_sw_pad_0 dl03d1 $PINS I=sw[0] Z=FE_PHN6_sw_pad_0 VSS=VSS_CORE
+ VDD=VDD_CORE
XFE_PHC5_sw_pad_1 dl03d1 $PINS I=sw[1] Z=FE_PHN5_sw_pad_1 VSS=VSS_CORE
+ VDD=VDD_CORE
XFE_PHC4_sw_pad_3 dl03d1 $PINS I=sw[3] Z=FE_PHN4_sw_pad_3 VSS=VSS_CORE
+ VDD=VDD_CORE
XFE_PHC3_sw_pad_2 dl03d1 $PINS I=sw[2] Z=FE_PHN3_sw_pad_2 VSS=VSS_CORE
+ VDD=VDD_CORE
XFE_PHC2_n_2 dl03d1 $PINS I=n_2 Z=FE_PHN2_n_2 VSS=VSS_CORE VDD=VDD_CORE
XFE_PHC1_uut_state_2 dl03d1 $PINS I=uut_state[2] Z=FE_PHN1_uut_state_2
+ VSS=VSS_CORE VDD=VDD_CORE
XFE_PHC0_n_1 dl03d1 $PINS I=n_1 Z=FE_PHN0_n_1 VSS=VSS_CORE VDD=VDD_CORE
Xuut_valid_out_reg dfcrq1 $PINS CDN=n_0 CP=clk D=FE_PHN10_n_9 Q=done_led
+ VSS=VSS_CORE VDD=VDD_CORE
Xuut_M_OUT_REAL_reg[3] decrq1 $PINS CDN=n_0 CP=clk D=FE_PHN4_sw_pad_3 ENN=n_5
+ Q=led[3] VSS=VSS_CORE VDD=VDD_CORE
Xuut_M_OUT_REAL_reg[0] decrq1 $PINS CDN=n_0 CP=clk D=FE_PHN6_sw_pad_0 ENN=n_5
+ Q=led[0] VSS=VSS_CORE VDD=VDD_CORE
Xuut_M_OUT_REAL_reg[1] decrq1 $PINS CDN=n_0 CP=clk D=FE_PHN5_sw_pad_1 ENN=n_5
+ Q=led[1] VSS=VSS_CORE VDD=VDD_CORE
Xg266__2398 nd02d1 $PINS A1=n_5 A2=n_7 ZN=n_9 VSS=VSS_CORE VDD=VDD_CORE
Xuut_M_OUT_REAL_reg[2] decrq1 $PINS CDN=n_0 CP=clk D=FE_PHN3_sw_pad_2 ENN=n_5
+ Q=led[2] VSS=VSS_CORE VDD=VDD_CORE
Xg269__5107 oan211d1 $PINS A=FE_PHN1_uut_state_2 B=n_3 C1=FE_PHN0_n_1
+ C2=uut_state[1] ZN=n_8 VSS=VSS_CORE VDD=VDD_CORE
Xg270__6260 oai21d1 $PINS A=done_led B1=uut_state[0] B2=uut_state[1] ZN=n_7
+ VSS=VSS_CORE VDD=VDD_CORE
Xuut_state_reg[2] dfcrq1 $PINS CDN=n_0 CP=clk D=n_6 Q=uut_state[2] VSS=VSS_CORE
+ VDD=VDD_CORE
Xg273__4319 nr03d1 $PINS A1=FE_PHN2_n_2 A2=FE_PHN1_uut_state_2 A3=FE_PHN0_n_1
+ ZN=n_6 VSS=VSS_CORE VDD=VDD_CORE
Xg274__8428 aoim211d1 $PINS A=uut_state[0] B=FE_PHN1_uut_state_2
+ C1=uut_state[1] C2=start ZN=n_4 VSS=VSS_CORE VDD=VDD_CORE
Xg275__5526 nd03d1 $PINS A1=FE_PHN0_n_1 A2=FE_PHN2_n_2 A3=FE_PHN1_uut_state_2
+ ZN=n_5 VSS=VSS_CORE VDD=VDD_CORE
Xg276__6783 nd02d1 $PINS A1=FE_PHN0_n_1 A2=uut_state[1] ZN=n_3 VSS=VSS_CORE
+ VDD=VDD_CORE
Xg279 inv0d1 $PINS I=FE_PHN11_rst_n_pad ZN=n_0 VSS=VSS_CORE VDD=VDD_CORE
Xuut_state_reg[1] dfcrb1 $PINS CDN=n_0 CP=clk D=FE_PHN9_n_8 Q=uut_state[1]
+ QN=n_2 VSS=VSS_CORE VDD=VDD_CORE
Xuut_state_reg[0] dfcrb1 $PINS CDN=n_0 CP=clk D=FE_PHN8_n_4 Q=uut_state[0]
+ QN=n_1 VSS=VSS_CORE VDD=VDD_CORE
.ENDS

.SUBCKT pqc_top_wrapper clk rst_n start sw[3] sw[2] sw[1] sw[0] led[3] led[2]
+ led[1] led[0] done_led
Xuut fpga_wrapper $PINS clk=clk_buf rst_n=rst_n_pad start=start_pad
+ sw[3]=sw_pad[3] sw[2]=sw_pad[2] sw[1]=sw_pad[1] sw[0]=sw_pad[0]
+ led[3]=led_pad[3] led[2]=led_pad[2] led[1]=led_pad[1] led[0]=led_pad[0]
+ done_led=done_led_pad VDD_CORE=VDD_CORE VSS_CORE=VSS_CORE
Xpc3c01_clk_buf pc3c01 $PINS CCLK=clk_pad CP=clk_buf VSSO=VSSO_CORE
+ VSS=VSS_CORE VDDO=VDDO_CORE VDD=VDD_CORE
Xpc3d01_clk pc3d01 $PINS PAD=clk CIN=clk_pad VSSO=VSSO_CORE VSS=VSS_CORE
+ VDDO=VDDO_CORE VDD=VDD_CORE
Xpc3d01_rst_n pc3d01 $PINS PAD=rst_n CIN=rst_n_pad VSSO=VSSO_CORE VSS=VSS_CORE
+ VDDO=VDDO_CORE VDD=VDD_CORE
Xpc3d01_start pc3d01 $PINS PAD=start CIN=start_pad VSSO=VSSO_CORE VSS=VSS_CORE
+ VDDO=VDDO_CORE VDD=VDD_CORE
Xpc3d01_sw0 pc3d01 $PINS PAD=sw[0] CIN=sw_pad[0] VSSO=VSSO_CORE VSS=VSS_CORE
+ VDDO=VDDO_CORE VDD=VDD_CORE
Xpc3d01_sw1 pc3d01 $PINS PAD=sw[1] CIN=sw_pad[1] VSSO=VSSO_CORE VSS=VSS_CORE
+ VDDO=VDDO_CORE VDD=VDD_CORE
Xpc3d01_sw2 pc3d01 $PINS PAD=sw[2] CIN=sw_pad[2] VSSO=VSSO_CORE VSS=VSS_CORE
+ VDDO=VDDO_CORE VDD=VDD_CORE
Xpc3d01_sw3 pc3d01 $PINS PAD=sw[3] CIN=sw_pad[3] VSSO=VSSO_CORE VSS=VSS_CORE
+ VDDO=VDDO_CORE VDD=VDD_CORE
Xpvdi_VDD_0 pvdi $PINS VSSO=VSSO_CORE VSS=VSS_CORE VDDO=VDDO_CORE VDD=VDD_CORE
Xpv0i_VSS_0 pv0i $PINS VSSO=VSSO_CORE VSS=VSS_CORE VDDO=VDDO_CORE VDD=VDD_CORE
Xpvda_VDDO_0 pvda $PINS VSSO=VSSO_CORE VSS=VSS_CORE VDDO=VDDO_CORE VDD=VDD_CORE
Xpv0a_VSSO_0 pv0a $PINS VSSO=VSSO_CORE VSS=VSS_CORE VDDO=VDDO_CORE VDD=VDD_CORE
Xpc3o01_dummy1 pc3o01 $PINS VSSO=VSSO_CORE VSS=VSS_CORE VDDO=VDDO_CORE
+ VDD=VDD_CORE
Xpc3o01_dummy2 pc3o01 $PINS VSSO=VSSO_CORE VSS=VSS_CORE VDDO=VDDO_CORE
+ VDD=VDD_CORE
Xpc3o01_dummy3 pc3o01 $PINS VSSO=VSSO_CORE VSS=VSS_CORE VDDO=VDDO_CORE
+ VDD=VDD_CORE
Xpvdi_VDD_1 pvdi $PINS VSSO=VSSO_CORE VSS=VSS_CORE VDDO=VDDO_CORE VDD=VDD_CORE
Xpv0i_VSS_1 pv0i $PINS VSSO=VSSO_CORE VSS=VSS_CORE VDDO=VDDO_CORE VDD=VDD_CORE
Xpvda_VDDO_1 pvda $PINS VSSO=VSSO_CORE VSS=VSS_CORE VDDO=VDDO_CORE VDD=VDD_CORE
Xpv0a_VSSO_1 pv0a $PINS VSSO=VSSO_CORE VSS=VSS_CORE VDDO=VDDO_CORE VDD=VDD_CORE
Xpc3o01_done_led pc3o01 $PINS I=done_led_pad PAD=done_led VSSO=VSSO_CORE
+ VSS=VSS_CORE VDDO=VDDO_CORE VDD=VDD_CORE
Xpvdi_VDD_2 pvdi $PINS VSSO=VSSO_CORE VSS=VSS_CORE VDDO=VDDO_CORE VDD=VDD_CORE
Xpv0i_VSS_2 pv0i $PINS VSSO=VSSO_CORE VSS=VSS_CORE VDDO=VDDO_CORE VDD=VDD_CORE
Xpvda_VDDO_2 pvda $PINS VSSO=VSSO_CORE VSS=VSS_CORE VDDO=VDDO_CORE VDD=VDD_CORE
Xpv0a_VSSO_2 pv0a $PINS VSSO=VSSO_CORE VSS=VSS_CORE VDDO=VDDO_CORE VDD=VDD_CORE
Xpvdi_VDD_3 pvdi $PINS VSSO=VSSO_CORE VSS=VSS_CORE VDDO=VDDO_CORE VDD=VDD_CORE
Xpv0i_VSS_3 pv0i $PINS VSSO=VSSO_CORE VSS=VSS_CORE VDDO=VDDO_CORE VDD=VDD_CORE
Xpvda_VDDO_3 pvda $PINS VSSO=VSSO_CORE VSS=VSS_CORE VDDO=VDDO_CORE VDD=VDD_CORE
Xpv0a_VSSO_3 pv0a $PINS VSSO=VSSO_CORE VSS=VSS_CORE VDDO=VDDO_CORE VDD=VDD_CORE
Xpc3o01_led0 pc3o01 $PINS I=led_pad[0] PAD=led[0] VSSO=VSSO_CORE VSS=VSS_CORE
+ VDDO=VDDO_CORE VDD=VDD_CORE
Xpc3o01_led1 pc3o01 $PINS I=led_pad[1] PAD=led[1] VSSO=VSSO_CORE VSS=VSS_CORE
+ VDDO=VDDO_CORE VDD=VDD_CORE
Xpc3o01_led2 pc3o01 $PINS I=led_pad[2] PAD=led[2] VSSO=VSSO_CORE VSS=VSS_CORE
+ VDDO=VDDO_CORE VDD=VDD_CORE
Xpc3o01_led3 pc3o01 $PINS I=led_pad[3] PAD=led[3] VSSO=VSSO_CORE VSS=VSS_CORE
+ VDDO=VDDO_CORE VDD=VDD_CORE
.ENDS
